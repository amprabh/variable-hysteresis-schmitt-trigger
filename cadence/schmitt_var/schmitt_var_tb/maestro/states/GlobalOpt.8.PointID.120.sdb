ADE simulation setup
Global variables:
  ratio_var = 1.1
  ratio_fb = 1.75
  ratio_in = 1.4
  PW = NW*ratio_in
  PW_FB = NW*ratio_fb
  NW = 16u
  NW_FB = 1u
  PBranchW_B = NBranchW_B*ratio_var
  PSwitchW_A = NSwitchW_A*ratio_var
  PSwitchW_B = NSwitchW_B*ratio_var
  PBranchW_A = NBranchW_A*ratio_var
  VDC = 1.8
  CTL0 = 1.8
  CTL1 = 1.8
  NBranchW_A = 3.5u
  NBranchW_B = 12.5u
  NSwitchW_A = 6.5u
  NSwitchW_B = 13.5u
