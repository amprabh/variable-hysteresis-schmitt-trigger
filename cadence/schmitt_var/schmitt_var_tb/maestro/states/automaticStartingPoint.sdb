ADE simulation setup
Global variables:
  ratio_fb = 0
  ratio_in = 0
  PW = 20.3u
  PW_FB = 550n
  NW = 10.2u
  NW_FB = 420n
  VDC = 1.8
  CTL0 = 0
  CTL1 = 0
Device parameters:
  capstone/6T_SCHMITT_VAR/schematic/NM_SwitchA.w = 3 * PM_BranchA/w@capstone/6T_SCHMITT_VAR/schematic
  capstone/6T_SCHMITT_VAR/schematic/NM_SwitchB.w = 3 * PM_BranchB/w@capstone/6T_SCHMITT_VAR/schematic
  capstone/6T_SCHMITT_VAR/schematic/PM_BranchA.w = 1u
  capstone/6T_SCHMITT_VAR/schematic/PM_BranchB.w = 2 * PM_BranchA/w@capstone/6T_SCHMITT_VAR/schematic
  capstone/6T_SCHMITT_VAR/schematic/NM_BranchA.w = 1u
  capstone/6T_SCHMITT_VAR/schematic/PM_SwitchA.w = 3 * NM_BranchA/w@capstone/6T_SCHMITT_VAR/schematic
  capstone/6T_SCHMITT_VAR/schematic/NM_BranchB.w = 2 * NM_BranchA/w@capstone/6T_SCHMITT_VAR/schematic
  capstone/6T_SCHMITT_VAR/schematic/PM_SwitchB.w = 3 * NM_BranchB/w@capstone/6T_SCHMITT_VAR/schematic
