ADE simulation setup
Test capstone_6T_SCHMITT_TB_1: schmitt_var/schmitt_var_tb/schematic, simulator spectre
  Models: /home/lab.apps/vlsiapps_new/kits/sky130_release_0.0.1/libs/sky130_fd_pr_main/../../models/sky130.lib.spice[tt]
  Variables: CTL0 = 0; CTL1 = 0
  Temperature: 27
  Analysis tran: stop=20u errpreset=conservative
  Analysis dc: sweep /V2.dc start=0 stop=1.8 (saves the operating point)
  Output V_LH = cross(VS("/OUT") 0.9 1 "falling" nil nil nil) (unticked)
  Output V_HL = cross(VS("/OUT") 0.9 1 "rising" nil nil nil) (unticked)
  Output target_width = if((VAR("CTL0") > 0.9) then if((VAR("CTL1") > 0.9) then 0.396 else 0.288) else if((VAR("CTL1") > 0.9) then 0.36 else 0.144))
  Output delta_V_trip = abs((V_LH - V_HL))
  Output delta_V_center = ((V_LH + V_HL) / 2)
  Output delay_LH = delay(VT("/IN") 0.9 1 "rising" VT("/OUT") 0.9 1 "falling")
  Output delay_HL = delay(VT("/IN") 0.9 1 "falling" VT("/OUT") 0.9 1 "rising")
  Output power = abs(average((i("/V1/PLUS" ?result "tran") * 1.8)))
  Output Hysterisis Error = abs((delta_V_trip - target_width))
  Signals: /OUT as Vout, /IN as Vin, /V1/PLUS (terminal)
Run mode: Single Run, Sweeps and Corners
Global variables:
  ratio_fb = 0
  ratio_in = 0
  PW = 16.3u
  PW_FB = 550n
  NW = 6.8u
  NW_FB = 420n
  VDC = 1.8
  CTL0 = 0
  CTL1 = 0
Device parameters (all switched off):
  capstone/6T_SCHMITT_VAR/schematic/NM_SwitchA.w = 1u (off)
  capstone/6T_SCHMITT_VAR/schematic/NM_SwitchB.w = 1u (off)
  capstone/6T_SCHMITT_VAR/schematic/PM_BranchA.w = 1u (off)
  capstone/6T_SCHMITT_VAR/schematic/PM_BranchB.w = 1u (off)
  capstone/6T_SCHMITT_VAR/schematic/NM_BranchA.w = 1u (off)
  capstone/6T_SCHMITT_VAR/schematic/PM_SwitchA.w = 1u (off)
  capstone/6T_SCHMITT_VAR/schematic/NM_BranchB.w = 1u (off)
  capstone/6T_SCHMITT_VAR/schematic/PM_SwitchB.w = 1u (off)
Corners (nominal off):
  State00: CTL0=0; CTL1=0
  State01: CTL0=1.8; CTL1=0
  State10: CTL0=0; CTL1=1.8
  State11: CTL0=1.8; CTL1=1.8
Specs:
  capstone_6T_SCHMITT_TB_1 / delta_V_center: range 0.88 to 0.92, weight 60
  capstone_6T_SCHMITT_TB_1 / delay_LH: < 100p, weight 20
  capstone_6T_SCHMITT_TB_1 / delay_HL: < 100p, weight 20
  capstone_6T_SCHMITT_TB_1 / power: min 50u, weight 10
  capstone_6T_SCHMITT_TB_1 / Hysterisis Error: < .01, weight 100
