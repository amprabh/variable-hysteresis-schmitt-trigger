ADE simulation setup
Run mode: Single Run, Sweeps and Corners
Tests:
  capstone_6T_SCHMITT_TB_1: schmitt_var/schmitt_var_tb/schematic, simulator spectre
    Variables: CTL0 = 0; CTL1 = 0
    Outputs: delay_LH; delay_HL; delta_V_center; target_width; power; Hysterisis Error
Global variables:
  ratio_fb = 0
  ratio_in = 0
  PW = 16.3u
  PW_FB = 550n
  NW = 6.8u
  NW_FB = 420n
  VDC = 1.8
  CTL0 = 0
  CTL1 = 0
Device parameters (all switched off):
  capstone/6T_SCHMITT_VAR/schematic/NM_SwitchA.w = 1u (off)
  capstone/6T_SCHMITT_VAR/schematic/NM_SwitchB.w = 1u (off)
  capstone/6T_SCHMITT_VAR/schematic/PM_BranchA.w = 1u (off)
  capstone/6T_SCHMITT_VAR/schematic/PM_BranchB.w = 1u (off)
  capstone/6T_SCHMITT_VAR/schematic/NM_BranchA.w = 1u (off)
  capstone/6T_SCHMITT_VAR/schematic/PM_SwitchA.w = 1u (off)
  capstone/6T_SCHMITT_VAR/schematic/NM_BranchB.w = 1u (off)
  capstone/6T_SCHMITT_VAR/schematic/PM_SwitchB.w = 1u (off)
Corners (nominal off):
  State00: CTL0=0; CTL1=0
  State01: CTL0=1.8; CTL1=0
  State10: CTL0=0; CTL1=1.8
  State11: CTL0=1.8; CTL1=1.8
Specs:
  capstone_6T_SCHMITT_TB_1 / delta_V_center: range 0.88 to 0.92, weight 60
  capstone_6T_SCHMITT_TB_1 / delay_LH: < 100p, weight 20
  capstone_6T_SCHMITT_TB_1 / delay_HL: < 100p, weight 20
  capstone_6T_SCHMITT_TB_1 / power: min 50u, weight 10
  capstone_6T_SCHMITT_TB_1 / Hysterisis Error: < .01, weight 100
